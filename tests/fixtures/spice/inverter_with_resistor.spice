* SKY130 CMOS Inverter with Load Resistor
* This netlist has an extra resistor not present in a standard inverter layout.
* Used for LVS mismatch testing (missing_device in layout).
*
* Ports: VDD (power), VSS (ground), IN (gate input), OUT (drain output)

.subckt INVERTER VDD VSS IN OUT

MPMOS OUT IN VDD VDD PMOS W=0.84e-6 L=0.15e-6
MNMOS OUT IN VSS VSS NMOS W=0.42e-6 L=0.15e-6
RLOAD OUT VSS RES R=10000

.ends INVERTER
